C3 GND /Power_supply/IN_P 22u
C4 /Power_supply/IN_N GND 22u
C15 GND /Power_supply/IN_N 1u
C14 /Power_supply/IN_P GND 1u
C10 GND /V+ 100n
V4 GND /V- DC 5
V3 /V+ GND DC 5
C20 /V+ GND 100n
C5 GND /V- 100n
C6 /V+ GND 100n
C21 GND /V- 100n
C1 /V+ GND 100n
C2 /V- GND 100n
C13 GND /offset_prec 1n
C16 /offset GND 100n
V5 /offset GND DC 1
R10 /offset_prec GND 1k
R9 /offset_prec /offset 99k
R7 /OUT /OutPad 10
XU2 /IN_P Net-_U2--_ /V+ /V- /OUT unconnected-_U2-_DIS-Pad5_ OPA847_Model
R8 GND /OutPad 50
C11 GND /OutPad 102p
R5 Net-_U2--_ Net-_R4-Pad2_ 1k
XU1 /IN_N Net-_U1--_ /V+ /V- Net-_R4-Pad2_ unconnected-_U1-_DIS-Pad5_ OPA847_Model
R4 Net-_R4-Pad2_ Net-_U1--_ 1k
R3 /offset_prec Net-_U1--_ 1k
R6 /OUT Net-_U2--_ 1k
V1 /Pad_P /Pad_N DC 0 SIN( 0 1 1k 0 0 0 ) AC 1
R1 /Pad_P /IN_P 100
R2 /Pad_N /IN_N 100
V2 /Pad_N GND DC 0.1
.end
